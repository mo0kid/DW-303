DW303 MEG trigger accent sweep and transistor cutoff converter
.include models.inc
.include env-stage.inc
.include control-stage.inc
.param DECAY=.5 ACC=0 RES=.5 CUT=.5 MOD=.5 TM3=235k
* VERIFY: independent ideal gate/latch inputs omit Q36/C72 gate shaping.
* Single normal trigger by default; runner also supplies finite accent trains.
Vngate ngate 0 PWL(0 12 .01 12 .010001 0 .0725 0 .072501 12)
Vact act 0 {ACC}
Xenv ngate act pulse meg env acc ENV DECAY={DECAY}
Xcontrol env acc current sweep c13 CONTROL CUT={CUT} MOD={MOD} RES={RES} TM3={TM3}
.options reltol=1e-5 abstol=1e-11
.control
set wr_singlescale
set wr_vecnames
set numdgt=12
tran .25m 4 0 100u
wrdata data.txt v(pulse) v(meg) v(env) v(acc) v(sweep) v(c13) v(current) v(xcontrol.vq9)
quit
.endc
.end
